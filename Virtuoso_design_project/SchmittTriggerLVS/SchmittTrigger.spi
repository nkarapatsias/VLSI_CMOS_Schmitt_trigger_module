* +++++++++++++++++++++++++++++++++++++++++++++++++++++++++ *
* CDL Netlist:                                              *
*                                                           *
* Cell Name  : SchmittTrigger                               *
* Netlisted  : Sun Jan  4 12:59:01 2026                     *
* PVS Version: 21.12-s022 Wed Feb 9 12:12:42 PST 2022      *
* +++++++++++++++++++++++++++++++++++++++++++++++++++++++++ *
*.LDD
*.DEVTMPLT 0 MN(g45n1svt) _nmos1v ndiff_conn(D) poly_conn(G) ndiff_conn(S) psubstrate(B)
*.DEVTMPLT 1 MP(g45p1svt) _pmos1v pdiff_conn(D) poly_conn(G) pdiff_conn(S) nwell_conn(B)

* +++++++++++++++++++++++++++++++++++++++++++++++++++++++++ *
* Sub cell: nmos1v_CDNS_5                                   *
* +++++++++++++++++++++++++++++++++++++++++++++++++++++++++ *
.subckt nmos1v_CDNS_5 1 2 3
** N=3 EP=3 FDC=1
M0 2 3 1 1 g45n1svt L=4.5e-08 W=5e-07 AD=7e-14 AS=7e-14 PD=1.28e-06 PS=1.28e-06 fw=5e-07 sa=1.4e-07 sb=1.4e-07 sca=8.71081 scb=0.0068183 scc=0.000305461 $X=0 $Y=0 $dt=0
.ends nmos1v_CDNS_5

* +++++++++++++++++++++++++++++++++++++++++++++++++++++++++ *
* Sub cell: pmos1v_CDNS_7                                   *
* +++++++++++++++++++++++++++++++++++++++++++++++++++++++++ *
.subckt pmos1v_CDNS_7 1 2 3 4
** N=4 EP=4 FDC=1
M0 2 3 1 4 g45p1svt L=6.5e-08 W=4.9e-07 AD=6.86e-14 AS=6.86e-14 PD=1.26e-06 PS=1.26e-06 fw=4.9e-07 sa=1.4e-07 sb=1.4e-07 sca=13.1367 scb=0.0112342 scc=0.00101587 $X=0 $Y=0 $dt=1
.ends pmos1v_CDNS_7

* +++++++++++++++++++++++++++++++++++++++++++++++++++++++++ *
* Sub cell: pmos1v_CDNS_8                                   *
* +++++++++++++++++++++++++++++++++++++++++++++++++++++++++ *
.subckt pmos1v_CDNS_8 1 2 3
** N=4 EP=3 FDC=1
M0 2 3 1 1 g45p1svt L=4.5e-08 W=1e-06 AD=1.4e-13 AS=1.4e-13 PD=2.28e-06 PS=2.28e-06 fw=1e-06 sa=1.4e-07 sb=1.4e-07 sca=20.9903 scb=0.0198554 scc=0.00149303 $X=0 $Y=0 $dt=1
.ends pmos1v_CDNS_8

* +++++++++++++++++++++++++++++++++++++++++++++++++++++++++ *
* Sub cell: nmos1v_CDNS_10                                  *
* +++++++++++++++++++++++++++++++++++++++++++++++++++++++++ *
.subckt nmos1v_CDNS_10 1 2 3 4
** N=4 EP=4 FDC=1
M0 2 3 1 4 g45n1svt L=4.5e-08 W=2.8e-07 AD=3.92e-14 AS=3.92e-14 PD=8.4e-07 PS=8.4e-07 fw=2.8e-07 sa=1.4e-07 sb=1.4e-07 sca=10.0252 scb=0.00891394 scc=0.000329703 $X=0 $Y=0 $dt=0
.ends nmos1v_CDNS_10

* +++++++++++++++++++++++++++++++++++++++++++++++++++++++++ *
* Sub cell: SchmittTrigger                                  *
* +++++++++++++++++++++++++++++++++++++++++++++++++++++++++ *
.subckt SchmittTrigger Gnd In Out Vdd
** N=7 EP=4 FDC=8
X8 Gnd Out 2 nmos1v_CDNS_5 $T=4930 1330 0 0 $X=4510 $Y=1130
X11 7 Gnd 2 Vdd pmos1v_CDNS_7 $T=2730 3080 0 0 $X=2310 $Y=2880
X12 Vdd Out 2 pmos1v_CDNS_8 $T=4930 2970 0 0 $X=4510 $Y=2770
X15 6 Vdd 2 Gnd nmos1v_CDNS_10 $T=2730 1710 0 0 $X=2310 $Y=1510
M0 Gnd In 6 Gnd g45n1svt L=4.5e-08 W=1.2e-07 AD=1.68e-14 AS=1.68e-14 PD=5.2e-07 PS=5.2e-07 fw=1.2e-07 sa=1.4e-07 sb=1.4e-07 sca=4.10409 scb=0.000241229 scc=2.8103e-08 $X=1400 $Y=900 $dt=0
M1 2 In 6 Gnd g45n1svt L=4.5e-08 W=1.2e-07 AD=1.68e-14 AS=1.68e-14 PD=5.2e-07 PS=5.2e-07 fw=1.2e-07 sa=1.4e-07 sb=1.4e-07 sca=10.975 scb=0.0105653 scc=0.000345649 $X=1400 $Y=1950 $dt=0
M2 2 In 7 Vdd g45p1svt L=4.5e-08 W=2.4e-07 AD=3.36e-14 AS=3.36e-14 PD=7.6e-07 PS=7.6e-07 fw=2.4e-07 sa=1.4e-07 sb=1.4e-07 sca=36.2991 scb=0.0347073 scc=0.00398904 $X=1400 $Y=3000 $dt=1
M3 Vdd In 7 Vdd g45p1svt L=4.5e-08 W=2.4e-07 AD=3.36e-14 AS=3.36e-14 PD=7.6e-07 PS=7.6e-07 fw=2.4e-07 sa=1.4e-07 sb=1.4e-07 sca=13.1804 scb=0.0123514 scc=0.000373537 $X=1400 $Y=4250 $dt=1
.ends SchmittTrigger
