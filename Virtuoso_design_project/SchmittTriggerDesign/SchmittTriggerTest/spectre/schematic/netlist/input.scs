// Design: SchmittTriggerDesign/SchmittTriggerTest
simulator lang=spectre
global 0
include "/mnt/apps/prebuilt/EDA/designkits/GPDK/gpdk045_v_6_0/gpdk045/../models/spectre/gpdk045.scs" section=tt

// SchmittTriggerDesign/SchmittTrigger/schematic
subckt SchmittTrigger Gnd In Out Vdd
    NM0 (net36 In net37 Gnd) g45n1svt w=(250n) l=45n nf=1 m=(1)
    NM1 (net37 In Gnd Gnd) g45n1svt w=(250n) l=45n nf=1 m=(1)
    NM4 (Vdd net36 net37 Gnd) g45n1svt w=(135n) l=45n nf=1 m=(1)
    NM3 (Out net36 Gnd Gnd) g45n1svt w=(500n) l=45n nf=1 m=(1)
    PM0 (net36 In net38 Vdd) g45p1svt w=(490n) l=45n nf=1 m=(1)
    PM1 (net38 In Vdd Vdd) g45p1svt w=(490n) l=45n nf=1 m=(1)
    PM2 (Gnd net36 net38 Vdd) g45p1svt w=(305n) l=45n nf=1 m=(1)
    PM3 (Out net36 Vdd Vdd) g45p1svt w=(1u) l=45n nf=1 m=(1)
ends SchmittTrigger

// SchmittTriggerDesign/SchmittTriggerTest/schematic
I0 (Gnd net1 net2 Vdd) SchmittTrigger
V0 (Vdd 0) vsource dc=1.2 type=dc
GND (Gnd 0) vsource dc=0 type=dc
C0 (net2 0) capacitor c=200f
V2 (net1 0) vsource type=pulse val0=0.3V val1=900.0m period=20n rise=10n fall=10n width=0
simulatorOptions options temp=27
tran tran stop=40n
